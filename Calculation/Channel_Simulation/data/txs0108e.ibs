| TEXAS INSTRUMENTS INCORPORATED
| Standard Linear and Logic Group
| IBIS Model of TXS01081BIT_IBIS
| 8-BIT BIDIRECTIONAL VOLTAGE-LEVEL TRANSLATOR WITH AUTO DIRECTION
| SENSING AND +/-15KV ESD PROTECTION
| This file contains package information for the following:
|  TSSOP 20-pin (PW) package as [Component] TXS01081BIT_IBIS_PW
|  QFN 20-pin (RGY) package as [Component] TXS01081BIT_IBIS_RGY
| This device can be powered at the following Vccs:
|  5 volt Vcc
|  3.3 volt Vcc
|  2.5 volt Vcc
|  1.8 volt Vcc
|  1.5 volt Vcc
|  1.2 volt Vcc
| This file provides unique models under the [Model Selector] for each Vcc.
| For operation at a specific Vcc, select the appropriate model after each
| [Model Selector] keyword.
[IBIS Ver]   3.2
[Comment char]  |_char
[File Name]   txs0108e.ibs
[File Rev]   1.0 | x_die
[Date]   May 9, 2009
[Source]   Data created from TI-SPICE simulations at TI-SLL.
[Notes]   The following is an IBIS list for the TXS0108E.
   Please contact sllibis@ti.com with questions and
   comments concerning SLL IBIS models.
   Pullup and Pulldown non-monotonic reflects circuit behavior
   IOB and IOA I/O buffers
[Disclaimer] Property of Texas Instruments Incorporated.  Unauthorized
                reproduction and/or distribution is strictly prohibited.
                This product is protected under copyright law.
                Created  2009, (C) Copyright  2009, Texas Instruments
                Incorporated, All Rights Reserved
                UNLESS THERE IS A SIGNED, WRITTEN AGREEMENT TO THE
                CONTRARY, TEXAS INSTRUMENTS (TI) IS PROVIDING THE IBIS
                MODELS  AND WITHOUT ANY WARRANTY, EXPRESSED OR
                IMPLIED.  TI assumes no liability for:
                 1) the accuracy of the IBIS models provided to your
                    company;
                 2) the proper functioning of these IBIS Models in your
                    design or for any resulting applications; or
                 3) infringement of patents, copyrights or intellectual
                    property rights resulting from your use of these IBIS
                    models.
                TI provides IBIS Models as a service to our customers.
                You and your company shall not distribute, sell or give
                these models to anyone else without prior written
                permission from TI.
                TI reserves the right to make changes to our products or
                to discontinue any semiconductor product or service
                without notice, and advises our customers to obtain the
                latest version of relevant information to verify, before
                placing orders, that the information being relied on is
                current.
                Please be aware that your receipt and use of the IBIS
                information provided shall serve as acceptance of these
                terms and conditions.  If you do not accept these terms,
                you should return or destroy the IBIS models and any
                other accompanying information immediately.
| Component TXS0108E_PW 20-PIN TSSOP
[Component]   TXS0108E_PW
[Manufacturer]   Texas Instruments, Inc.
[Package]
|   typ   min   max
R_pkg   5.000e-02   4.200e-02   6.000e-02
L_pkg   2.802e-09   2.248e-09   3.553e-09
C_pkg   3.170e-13   2.020e-13   4.430e-13
[Pin]   signal_name   model_name   R_pin   L_pin   C_pin
1   A1   TXS0108_IN_18   5.500e-02   3.461e-09   4.400e-13
2   VCCA   POWER   5.500e-02   3.150e-09   4.010e-13
3   A2   TXS0108_IN_18   4.200e-02   2.619e-09   3.020e-13
4   A3   TXS0108_IOA   4.500e-02   2.273e-09   2.020e-13
5   A4   TXS0108_IOA   4.500e-02   2.248e-09   2.240e-13
6   A5   TXS0108_IOA   4.500e-02   2.273e-09   2.260e-13
7   A6   TXS0108_IOA   4.400e-02   2.323e-09   2.050e-13
8   A7   TXS0108_IOA   4.600e-02   2.704e-09   3.070e-13
9   A8   TXS0108_IOA   6.000e-02   3.265e-09   4.110e-13
10   OE   TXS0108_IN   5.700e-02   3.506e-09   4.360e-13
11   GND   GND   5.800e-02   3.553e-09   4.370e-13
12   B8   TXS0108_IOB   5.800e-02   3.193e-09   4.050e-13
13   B7   TXS0108_IOB   4.200e-02   2.704e-09   3.110e-13
14   B6   TXS0108_IOB   4.600e-02   2.392e-09   2.100e-13
15   B5   TXS0108_IOB   4.700e-02   2.334e-09   2.290e-13
16   B4   TXS0108_IOB   4.700e-02   2.300e-09   2.270e-13
17   B3   TXS0108_IOB   4.700e-02   2.349e-09   2.070e-13
18   B2   TXS0108_IOB   4.500e-02   2.677e-09   3.060e-13
19   VCCB   POWER   6.000e-02   3.235e-09   4.060e-13
20   B1   TXS0108_IOB   5.600e-02   3.487e-09   4.430e-13
| Component TXS0108E_RGY 20-PIN QFN
[Component]   TXS0108E_RGY
[Manufacturer]   Texas Instruments, Inc.
[Package]
|   typ   min   max
R_pkg   5.000e-02   4.600e-02   5.500e-02
L_pkg   1.119e-09   1.025e-09   1.227e-09
C_pkg   3.520e-13   3.440e-13   3.630e-13
[Pin]   signal_name   model_name   R_pin   L_pin   C_pin
1   A1   TXS0108_IN_18   5.200e-02   1.167e-09   3.600e-13
2   VCCA   POWER   4.700e-02   1.049e-09   3.440e-13
3   A2   TXS0108_IOA   4.700e-02   1.055e-09   3.450e-13
4   A3   TXS0108_IOA   5.000e-02   1.119e-09   3.500e-13
5   A4   TXS0108_IOA   5.500e-02   1.227e-09   3.600e-13
6   A5   TXS0108_IOA   5.200e-02   1.167e-09   3.550e-13
7   A6   TXS0108_IOA   4.900e-02   1.087e-09   3.480e-13
8   A7   TXS0108_IOA   4.700e-02   1.054e-09   3.460e-13
9   A8   TXS0108_IOA   4.900e-02   1.091e-09   3.490e-13
10   OE   TXS0108_IN   5.300e-02   1.184e-09   3.620e-13
11   GND   GND   5.300e-02   1.181e-09   3.600e-13
12   B8   TXS0108_IOB   5.000e-02   1.108e-09   3.490e-13
13   B7   TXS0108_IOB   4.800e-02   1.075e-09   3.470e-13
14   B6   TXS0108_IOB   5.000e-02   1.107e-09   3.490e-13
15   B5   TXS0108_IOB   5.400e-02   1.200e-09   3.620e-13
16   B4   TXS0108_IOB   5.100e-02   1.141e-09   3.570e-13
17   B3   TXS0108_IOB   4.700e-02   1.043e-09   3.440e-13
18   B2   TXS0108_IOB   4.600e-02   1.025e-09   3.440e-13
19   VCCB   POWER   4.900e-02   1.090e-09   3.490e-13
20   B1   TXS0108_IOB   5.400e-02   1.204e-09   3.630e-13
| Component TXS0108E_ZXY 20-PIN u*Jr BGA
[Component]   TXS0108E_ZXY
[Manufacturer]   Texas Instruments, Inc.
[Package]
|   typ   min   max
R_pkg   0.057703   0.05127   0.06781
L_pkg   1.1577665n  0.99154n   1.48216n
C_pkg   0.1802725p  0.13673p   0.22855p
[Pin]   signal_name   model_name   R_pin   L_pin   C_pin
1   A8   TXS0108_IOA   0.05373   1.01871n   0.15665p
2   A7   TXS0108_IOA   0.06276   1.39916n   0.21753p
3   A6   TXS0108_IOA   0.05433   1.01804n   0.18684p
4   A5   TXS0108_IOA   0.06043   1.35595n   0.22385p
5   A4   TXS0108_IOA   0.05268   0.99154n   0.18368p
6   A3   TXS0108_IOA   0.05974   1.35105n   0.21539p
7   A2   TXS0108_IOA   0.05308   1.00780n   0.16664p
8   VCCA   POWER   0.05705   1.02274n   0.16511p
9   A1   TXS0108_IN_18   0.05192   1.03338n   0.13766p
10   B1   TXS0108_IOB   0.05127   1.02319n   0.13673p
11   VCCB   POWER   0.06180   1.16248n   0.14894p
12   B2   TXS0108_IOB   0.05734   1.07561n   0.17217p
13   B3   TXS0108_IOB   0.06444   1.42639n   0.22198p
14   B4   TXS0108_IOB   0.05770   1.07442n   0.18915p
15   B5   TXS0108_IOB   0.06564   1.44558n   0.22855p
16   B6   TXS0108_IOB   0.05938   1.10463n   0.19337p
17   B7   TXS0108_IOB   0.06781   1.48216n   0.22458p
18   B8   TXS0108_IOB   0.05895   1.10793n   0.16240p
19   GND   GND   0.05168   1.02154n   0.13715p
20   OE   TXS0108_IN   0.05233   1.03303n   0.13708p
| Component TXS0108E_NME 20-PIN u*Jr BGA
[Component]   TXS0108E_NME
[Manufacturer]   Texas Instruments, Inc.
[Package]
|   typ   min   max
R_pkg   0.057703   0.05127   0.06781
L_pkg   1.1577665n  0.99154n   1.48216n
C_pkg   0.1802725p  0.13673p   0.22855p
[Pin]   signal_name   model_name   R_pin   L_pin   C_pin
1   A8   TXS0108_IOA   0.05373   1.01871n   0.15665p
2   A7   TXS0108_IOA   0.06276   1.39916n   0.21753p
3   A6   TXS0108_IOA   0.05433   1.01804n   0.18684p
4   A5   TXS0108_IOA   0.06043   1.35595n   0.22385p
5   A4   TXS0108_IOA   0.05268   0.99154n   0.18368p
6   A3   TXS0108_IOA   0.05974   1.35105n   0.21539p
7   A2   TXS0108_IOA   0.05308   1.00780n   0.16664p
8   VCCA   POWER   0.05705   1.02274n   0.16511p
9   A1   TXS0108_IN_18   0.05192   1.03338n   0.13766p
10   B1   TXS0108_IOB   0.05127   1.02319n   0.13673p
11   VCCB   POWER   0.06180   1.16248n   0.14894p
12   B2   TXS0108_IOB   0.05734   1.07561n   0.17217p
13   B3   TXS0108_IOB   0.06444   1.42639n   0.22198p
14   B4   TXS0108_IOB   0.05770   1.07442n   0.18915p
15   B5   TXS0108_IOB   0.06564   1.44558n   0.22855p
16   B6   TXS0108_IOB   0.05938   1.10463n   0.19337p
17   B7   TXS0108_IOB   0.06781   1.48216n   0.22458p
18   B8   TXS0108_IOB   0.05895   1.10793n   0.16240p
19   GND   GND   0.05168   1.02154n   0.13715p
20   OE   TXS0108_IN   0.05233   1.03303n   0.13708p
| Model TXS0108_IN
[Model Selector]   TXS0108_IN
TXS0108_IN_50   5 volt Vcc
TXS0108_IN_33   3.3 volt Vcc
TXS0108_IN_25   2.5 volt Vcc
TXS0108_IN_18   1.8 volt Vcc
TXS0108_IN_15A   1.5 volt Vcc
TXS0108_IN_12A   1.2 volt Vcc
| Model TXS0108_IOB
[Model Selector]   TXS0108_IOB
TXS0108_IOB_OS_50   5 volt Vcc
TXS0108_IOB_OS_33   3.3 volt Vcc
TXS0108_IOB_OS_25   2.5 volt Vcc
TXS0108_IOB_OS_18   1.8 volt Vcc
TXS0108_IOB_OS_15A   1.5 volt Vcc
TXS0108_IOB_OS_12A   1.2 volt Vcc
| Model TXS0108_IOA
[Model Selector]   TXS0108_IOA
TXS0108_IOA_OS_50   5 volt Vcc
TXS0108_IOA_OS_33   3.3 volt Vcc
TXS0108_IOA_OS_25   2.5 volt Vcc
TXS0108_IOA_OS_18   1.8 volt Vcc
TXS0108_IOA_OS_15A   1.5 volt Vcc
TXS0108_IOA_OS_12A   1.2 volt Vcc
| Models and submodels in the file (18): TXS0108_IN_50 (Input), TXS0108_IN_33 (Input), TXS0108_IN_25 (Input), TXS0108_IN_18 (Input), TXS0108_IN_15A (Input), TXS0108_IN_12A (Input), TXS0108_IOB_OS_50 (I/O), TXS0108_IOB_OS_33 (I/O), TXS0108_IOB_OS_25 (I/O), TXS0108_IOB_OS_18 (I/O), TXS0108_IOB_OS_15A (I/O), TXS0108_IOB_OS_12A (I/O), TXS0108_IOA_OS_50 (I/O), TXS0108_IOA_OS_33 (I/O), TXS0108_IOA_OS_25 (I/O), TXS0108_IOA_OS_18 (I/O), TXS0108_IOA_OS_15A (I/O), TXS0108_IOA_OS_12A (I/O)
